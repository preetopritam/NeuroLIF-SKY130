* ================================================================
* NeuroLIF-SKY130
* Complete LIF neuron physical reference V1
*
* Pre-silicon educational SKY130 design.
*
* Core:
*   7-MOS weighted synapse
*   1-MOS leak
*   6-MOS corrected Schmitt trigger
*   2-MOS output inverter
*   1-MOS reset
*
* Total MOS = 17
*
* External membrane capacitance:
*   CMEM = 5 pF from VMEM to VSS in the simulation/testbench.
*   It is NOT physically instantiated in this core revision.
*
* MOS syntax:
*   Mname D G S B model W=... L=...
* ================================================================

* ================================================================
* CLOSED WEIGHTED SYNAPSE
* ================================================================

.SUBCKT NEUROLIF_WEIGHTED_SYNAPSE VDD VSS VBIAS GATE_W0 GATE_W1 VMEM

* PMOS reference
MP_REF VBIAS VBIAS VDD VDD sky130_fd_pr__pfet_01v8 W=0.84u L=0.50u

* Three identical PMOS unit sources
MP_U1A N_U1A VBIAS VDD VDD sky130_fd_pr__pfet_01v8 W=0.84u L=0.50u

MP_U0 N_U0 VBIAS VDD VDD sky130_fd_pr__pfet_01v8 W=0.84u L=0.50u

MP_U1B N_U1B VBIAS VDD VDD sky130_fd_pr__pfet_01v8 W=0.84u L=0.50u

* Three identical NMOS selection switches
MN_SW1A N_U1A GATE_W1 VMEM VSS sky130_fd_pr__nfet_01v8 W=1.00u L=0.15u

MN_SW0 N_U0 GATE_W0 VMEM VSS sky130_fd_pr__nfet_01v8 W=1.00u L=0.15u

MN_SW1B N_U1B GATE_W1 VMEM VSS sky130_fd_pr__nfet_01v8 W=1.00u L=0.15u

.ENDS NEUROLIF_WEIGHTED_SYNAPSE

* ================================================================
* COMPLETE NEURON CORE
* ================================================================

.SUBCKT NEUROLIF_FULL_NEURON_V1 VDD VSS VBIAS GATE_W0 GATE_W1 VLEAK VMEM SPIKE

* ------------------------------------------------
* Closed weighted-synapse block
* ------------------------------------------------

XWS VDD VSS VBIAS GATE_W0 GATE_W1 VMEM NEUROLIF_WEIGHTED_SYNAPSE

* ------------------------------------------------
* Membrane leak
*
* D = VMEM
* G = VLEAK
* S = VSS
* B = VSS
* ------------------------------------------------

MN_LEAK VMEM VLEAK VSS VSS sky130_fd_pr__nfet_01v8 W=0.42u L=1.00u

* ================================================================
* CORRECTED 6T SCHMITT THRESHOLD DETECTOR
*
* Input  = VMEM
* Output = VRAW
*
* Internal nodes:
*   P_MID
*   N_MID
* ================================================================

* ------------------------------------------------
* PMOS input stack
* ------------------------------------------------

MP_ST1 P_MID VMEM VDD VDD sky130_fd_pr__pfet_01v8 W=2.00u L=0.15u

MP_ST2 VRAW VMEM P_MID VDD sky130_fd_pr__pfet_01v8 W=2.00u L=0.15u

* ------------------------------------------------
* NMOS input stack
* ------------------------------------------------

MN_ST1 VRAW VMEM N_MID VSS sky130_fd_pr__nfet_01v8 W=1.00u L=0.15u

MN_ST2 N_MID VMEM VSS VSS sky130_fd_pr__nfet_01v8 W=1.00u L=0.15u

* ------------------------------------------------
* CORRECTED feedback devices
*
* DO NOT substitute the older crossed-feedback form.
* ------------------------------------------------

MN_FB VDD VRAW N_MID VSS sky130_fd_pr__nfet_01v8 W=0.42u L=0.30u

MP_FB VSS VRAW P_MID VDD sky130_fd_pr__pfet_01v8 W=0.42u L=0.30u

* ================================================================
* OUTPUT INVERTER
*
* Converts Schmitt raw output VRAW into positive SPIKE.
* ================================================================

MP_BUF SPIKE VRAW VDD VDD sky130_fd_pr__pfet_01v8 W=2.00u L=0.15u

MN_BUF SPIKE VRAW VSS VSS sky130_fd_pr__nfet_01v8 W=1.00u L=0.15u

* ================================================================
* DIRECT SPIKE-CONTROLLED RESET
*
* D = VMEM
* G = SPIKE
* S = VSS
* B = VSS
* ================================================================

MN_RST VMEM SPIKE VSS VSS sky130_fd_pr__nfet_01v8 W=1.20u L=0.15u

.ENDS NEUROLIF_FULL_NEURON_V1
