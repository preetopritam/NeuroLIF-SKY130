* Extracted by KLayout with SKY130 LVS runset on : 30/10/2026 17:42

* cell NEUROLIF_WEIGHTED_SYNAPSE_LVS_V1
* pin GATE_W0
* pin GATE_W1
* pin VBIAS
* pin VDD
* pin VMEM
* pin VSS
.SUBCKT NEUROLIF_WEIGHTED_SYNAPSE_LVS_V1 GATE_W0 GATE_W1 VBIAS VDD VMEM VSS
* device instance $1 r0 *1 0.55,3 sky130_fd_pr__nfet_01v8
M$1 VMEM GATE_W1 \$I1 VSS sky130_fd_pr__nfet_01v8 L=0.15 W=1 AS=0.3 AD=0.3
+ PS=2.6 PD=2.6
* device instance $2 r0 *1 6.55,3 sky130_fd_pr__nfet_01v8
M$2 VMEM GATE_W0 \$I2 VSS sky130_fd_pr__nfet_01v8 L=0.15 W=1 AS=0.3 AD=0.3
+ PS=2.6 PD=2.6
* device instance $3 r0 *1 9.55,3 sky130_fd_pr__nfet_01v8
M$3 VMEM GATE_W1 \$I3 VSS sky130_fd_pr__nfet_01v8 L=0.15 W=1 AS=0.3 AD=0.3
+ PS=2.6 PD=2.6
* device instance $4 r0 *1 0.55,8.42 sky130_fd_pr__pfet_01v8
M$4 VDD VBIAS \$I1 VDD sky130_fd_pr__pfet_01v8 L=0.5 W=0.84 AS=0.252 AD=0.252
+ PS=2.28 PD=2.28
* device instance $5 r0 *1 9.55,8.42 sky130_fd_pr__pfet_01v8
M$5 VDD VBIAS \$I3 VDD sky130_fd_pr__pfet_01v8 L=0.5 W=0.84 AS=0.252 AD=0.252
+ PS=2.28 PD=2.28
* device instance $6 r0 *1 6.55,8.42 sky130_fd_pr__pfet_01v8
M$6 VDD VBIAS \$I2 VDD sky130_fd_pr__pfet_01v8 L=0.5 W=0.84 AS=0.252 AD=0.252
+ PS=2.28 PD=2.28
* device instance $7 r0 *1 3.55,8.42 sky130_fd_pr__pfet_01v8
M$7 VDD VBIAS VBIAS VDD sky130_fd_pr__pfet_01v8 L=0.5 W=0.84 AS=0.252 AD=0.252
+ PS=2.28 PD=2.28
.ENDS NEUROLIF_WEIGHTED_SYNAPSE_LVS_V1
